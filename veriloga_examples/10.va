// PARAMSET
paramset nch nmos3; // default paramset
    parameter real l=1u from [0.25u:inf);
    parameter real w=1u from [0.2u:inf);
    .l=l; .w=w; .ad=w*0.5u; .as=w*0.5u;
    .kp=5e-5; .tox=3e-8; .u0=650; .nsub=1.3e17;
    .vmax=0; .tpg=1; .nfs=0.8e12;
endparamset

module semicoCMOS ();
    localparam real tox = 3e-8;
    localparam real dtox_g = $rdist_normal(1,0,1n,"global");
    localparam real dtox_mm = $rdist_normal(2,0,5n,"instance");
endmodule
