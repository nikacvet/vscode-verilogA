module hello_world ;
    analog
    begin
    @(initial_step)
    $strobe("Hello World!") ;
    end
endmodule
